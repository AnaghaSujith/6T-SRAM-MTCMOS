// Design: lpv_proj/WITH_SYM2
simulator lang=spectre
global 0
include "/home/workspace/cadence/IC615/45/gpdk045/../models/spectre/gpdk045.scs" section=NN

// lpv_proj/try1/schematic
subckt try1 BL BLB Q QB VCC WL gnd
    NM6 (BLB WL QB gnd) gpdk045_nmos1v w=(120n) l=45n nf=1 m=(1)
    NM1 (QB Q gnd gnd) gpdk045_nmos1v w=(120n) l=45n nf=1 m=(1)
    NM0 (Q QB gnd gnd) gpdk045_nmos1v w=(120n) l=45n nf=1 m=(1)
    PM1 (QB Q VCC VCC) gpdk045_pmos1v w=(120n) l=45n nf=1 m=(1)
    PM0 (Q QB VCC VCC) gpdk045_pmos1v w=(120n) l=45n nf=1 m=(1)
    NM3 (Q WL BL gnd) gpdk045_nmos1v_hvt w=(120n) l=45n nf=1 m=(1)
ends try1

// lpv_proj/WITH_SYM2/schematic
V5 (net06 0) vsource dc=500m type=dc
V4 (net09 0) vsource dc=0 type=dc
V3 (BL 0) vsource type=pulse val0=0 val1=500m period=50n rise=1n fall=1n width=25n
V2 (BLB 0) vsource type=pulse val0=500m val1=0 period=50n rise=1n fall=1n width=25n
V1 (WL 0) vsource type=pulse val0=0 val1=500m
I9 (BL BLB Q QB net6 WL net013) try1
NM0 (net013 net09 0 0) gpdk045_nmos1v_hvt w=(120n) l=45n nf=1 m=(1)
PM0 (net6 net06 net06 net06) gpdk045_pmos1v_hvt w=(120n) l=45n nf=1 m=(1)
simulatorOptions options temp=27
tran tran stop=100n errpreset=moderate
